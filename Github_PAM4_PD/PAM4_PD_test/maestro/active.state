ADE simulation setup
Test Github_PAM4_PD_PAM4_PD_test_1: Github_PAM4_PD/PAM4_PD_test/schematic, simulator spectre
  Models: /home/jabdekhoda/myhome/28nmtoplevel.scs[top_tt], /home/jabdekhoda/myhome/hpcplus/tcbn28hpcplusbwp30p140_110a.spi
  Variables: Icp = -100u; APPIN = 200m; DS = 1; Jrms = 0; PRBSN = 7; rfperc = 100m; SmpRt = 28G; VBIN = 0.8; CL = 10f; VINP = 200m; VINN = -200m; tr = 20p; trise = 1p; VDD = 1; resolution = 10m; vin = 200m; VIN_DC = 0.8; VREF = 133m; delay = -1.5p; UI = 1/SmpRt; TSTOP = 124*UI
  Temperature: 27
  Analysis tran: stop=VAR("TSTOP") errpreset=conservative
  Output average(v("/OUT" ?result "tran"))
  Signals: /OUT
Run mode: Single Run, Sweeps and Corners
Setup values for test Github_PAM4_PD_PAM4_PD_test_1: delay = {From/To}LinearStepCount:1p:10:2.5p{From/To}{From/To}LinearStepCount:-10p:5:0.5p{From/To}{From/To}LinearStepCount:3p:5:13p{From/To}

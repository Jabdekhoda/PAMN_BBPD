ADE simulation setup
Test PAM4_PD_PAM4_PD56Gb_LP_V0_PV2_1: PAM4_PD/PAM4_PD56Gb_LP_V0_PV2/schematic, simulator spectre
  Models: /home/jabdekhoda/myhome/28nmtoplevel.scs[top_tt], /home/jabdekhoda/myhome/hpcplus/tcbn28hpcplusbwp30p140_110a.spi
  Variables: APPIN = 0.2; DS = 1; Jrms = 0; PRBSN = 7; rfperc = 200m; SmpRt = 28G; VBIN = 0.8; CL = 10f; VINP = 200m; VINN = -200m; tr = 20p; trise = 1p; VDD = 1; VIN_DC = 0.8; VREF = 133m; vin = 200m; delay = 1.5p; UI = 1/SmpRt; TSTOP = 1034*UI
  Temperature: 27
  Analysis tran: stop=VAR("TSTOP") errpreset=conservative
  Output v (/ODP /ODN); tran (V) = (vtime('tran "/ODP") - vtime('tran "/ODN")) (unticked)
  Output v (/OEP /OEN); tran (V) = (vtime('tran "/OEP") - vtime('tran "/OEN")) (unticked)
  Output v (/OUTP /OUTN); tran (V) = (vtime('tran "/OUTP") - vtime('tran "/OUTN")) (unticked)
  Output v /CK4; tran (V) = vtime('tran "/CK4") (unticked)
  Output v /CK7; tran (V) = vtime('tran "/CK7") (unticked)
  Output v /CK5; tran (V) = vtime('tran "/CK5") (unticked)
  Output VCMD = ((vtime('tran "/ODP") + vtime('tran "/ODN")) / 2) (unticked)
  Output v /T1<2>; tran (V) = vtime('tran "/T1<2>") (unticked)
  Output v /DE_P; tran (V) = vtime('tran "/DE_P") (unticked)
  Output v /T0<1>; tran (V) = vtime('tran "/T0<1>") (unticked)
  Output v (/INP /INN); tran (V) = (vtime('tran "/INP") - vtime('tran "/INN")) (unticked)
  Output v /CK2; tran (V) = vtime('tran "/CK2") (unticked)
  Output v /CK1; tran (V) = vtime('tran "/CK1") (unticked)
  Output v /CK3; tran (V) = vtime('tran "/CK3") (unticked)
  Output value((vtime('tran "/A") - vtime('tran "/B")) (20 * VAR("UI"))) (unticked)
  Output PD_OUT = average((vtime('tran "/A") - vtime('tran "/B")))
  Output eyeDiagram(vtime('tran "/I0/net6") (2 / VAR("SmpRt")) 1e-05 (2 / VAR("SmpRt"))) (unticked)
  Output eyeDiagram(vtime('tran "/CK2") (2 / VAR("SmpRt")) 1e-05 (2 / VAR("SmpRt"))) (unticked)
  Output ((vtime('tran "/OUTP") + vtime('tran "/OUTN")) / 2) (unticked)
  Output average(itime('tran "/VDD_Logic/PLUS")) (unticked)
  Output average(itime('tran "/VDD_Edge/PLUS")) (unticked)
  Output (0.5 * average(itime('tran "/VDD_Data/PLUS"))) (unticked)
Run mode: Single Run, Sweeps and Corners
Setup values for test PAM4_PD_PAM4_PD56Gb_LP_V0_PV2_1: delay = {From/To}LinearStepCount:2p:5:3p{From/To}{From/To}LinearStepCount:-10p:5:1p{From/To}{From/To}LinearStepCount:4p:4:13p{From/To}

ADE simulation setup
Run mode: Single Run, Sweeps and Corners
Tests:
  PAM4_PD_PAM4_PD56Gb_LP_V0_PV2_1: PAM4_PD/PAM4_PD56Gb_LP_V0_PV2/schematic, simulator spectre
    Variables: APPIN = 0.2; DS = 1; Jrms = 0; PRBSN = 7; rfperc = 200m; SmpRt = 28G; VBIN = 0.8; CL = 10f; VINP = 200m; VINN = -200m; tr = 20p; trise = 1p; VDD = 1; VIN_DC = 0.8; VREF = 133m; vin = 200m; delay = {From/To}LinearStepCount:2p:5:3p{From/To}{From/To}LinearStepCount:-10p:5:1p{From/To}{From/To}LinearStepCount:4p:4:13p{From/To}; UI = 1/SmpRt; TSTOP = 1034*UI
